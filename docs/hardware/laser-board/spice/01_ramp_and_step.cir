* Laser board 01: the firmware's ramp to a set point, then small steps
*
* 1 ms at zero, a 20 ms ramp to ISET, a +1 mA step at 40 ms, back at
* 45 ms, and an abrupt switch-off at 60 ms. Stepped over the
* capacitance across the module, which is unknown.
*
* Plot: V(sns)*100 (sink current, mA), I(Vlas) (laser current),
*       V(opt) (light, mW), V(oa), V(gate), V(drn).
* Good: no overshoot on the ramp or the step, for every CMOD.
* KS is the volts on the sense resistor per amp asked of the DAC:
* 9.96, not 10, as the divider is 40.2k and 10k (calibrated out).

.include models.lib
.include board.inc
.options plotwinsize=0

.param ISET=40m VZ=0.8m LCAB=0.5u ACBRK=0 ACBRK2=0 KS=9.9602 C105V=0 RLID=0.1 VTS=0.75 VTC=1.3
.step param CMOD list 0 100n 1u 10u

V5 v5in 0 5
V3 v3 0 3.3
Ven en 0 3.3
Vdac dac 0 PWL(0 {VZ} 1m {VZ} 21m {ISET*50} 40m {ISET*50}
+ 40.001m {(ISET+1m)*50} 45m {(ISET+1m)*50} 45.001m {ISET*50}
+ 60m {ISET*50} 60.001m {VZ} 70m {VZ})

* the laser on its cable: change LASER2 to LASER1 ... LASER6 or DUMMY100
* (and ISET to suit: 44m, 41m, 21m, 22m, 18.5m, 11m at most)
Lcab v5 lasp {LCAB} Rser=0.2
Cmod lasp drn {CMOD+1f}
Vlas lasp lasa 0
Xlas lasa drn opt LASER2

.tran 0 70m 0 2u

.meas tran vpk_ramp max V(sns) from=0 to=39.9m
.meas tran over_ramp_ua param (vpk_ramp-ISET*KS)*1e5
.meas tran vpk_step max V(sns) from=40m to=44.9m
.meas tran over_step_ua param (vpk_step-(ISET+1m)*KS)*1e5
.meas tran t_step_90 trig V(dac)={(ISET+0.5m)*50} rise=1
+ targ V(sns)={(ISET+0.9m)*KS} rise=1
.meas tran ilas_pk max I(Vlas) from=0 to=59.9m
.meas tran ilas_pk_ma param ilas_pk*1e3
.meas tran light_mw find V(opt) at=39m
.meas tran headroom_v find V(drn,sns) at=39m

.end
