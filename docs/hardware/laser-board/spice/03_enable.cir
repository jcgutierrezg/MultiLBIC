* Laser board 03: the enable line, with the DAC already at its set point
*
* Off until 1 ms, on to 6 ms, off to 10 ms, then chopped at 1 kHz.
*
* Plot: V(en), V(laser_off), V(set), V(sns)*100 (mA), V(opt) (mW).
* Good: no overshoot when the clamp lets go; the laser dark while
* clamped. The 80 us of R101, R102 and C101 rounds the edges: this run
* shows how fast the enable can usefully be chopped.

.include models.lib
.include board.inc
.options plotwinsize=0

.param ISET=40m LCAB=0.5u ACBRK=0 ACBRK2=0 KS=9.9602 C105V=0 RLID=0.1 VTS=0.75 VTC=1.3
.step param CMOD list 0 1u

V5 v5in 0 5
V3 v3 0 3.3
Vdac dac 0 {ISET*50}
Ven en 0 PWL(0 0 1m 0 1.001m 3.3 6m 3.3 6.001m 0 10m 0
+ 10.001m 3.3 10.5m 3.3 10.501m 0 11m 0
+ 11.001m 3.3 11.5m 3.3 11.501m 0 12m 0
+ 12.001m 3.3 12.5m 3.3 12.501m 0 13m 0
+ 13.001m 3.3 13.5m 3.3 13.501m 0 14m 0)

Lcab v5 lasp {LCAB} Rser=0.2
Cmod lasp drn {CMOD+1f}
Vlas lasp lasa 0
Xlas lasa drn opt LASER2

.tran 0 14m 0 1u

.meas tran vpk_on max V(sns) from=1m to=6m
.meas tran over_on_ua param (vpk_on-ISET*KS)*1e5
.meas tran t_on_90 trig V(en)=1.65 rise=1 targ V(sns)={0.9*ISET*KS} rise=1
.meas tran t_off_10 trig V(en)=1.65 fall=1 targ V(sns)={0.1*ISET*KS} fall=1
.meas tran i_clamped avg I(Vlas) from=8m to=9.9m
.meas tran i_clamped_ua param i_clamped*1e6
.meas tran chop_pk max V(sns) from=13m to=13.5m
.meas tran chop_reach_pct param chop_pk/(ISET*KS)*100

.end
